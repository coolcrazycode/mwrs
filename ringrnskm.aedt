# Ansys Electronics Desktop project, version 2024.2
materials:
  vacuum: permittivity=1
  FR4_epoxy: permittivity=4.4 dielectric_loss_tangent=0.02
  air: permittivity=1.0006 permeability=1.0000004

design HFSSDesign1 (HFSS, HFSS Terminal Network, model units mm)
options: Allow_Material_Override
geometry:
  Circle1 = circle(normal=Z, centre=(0mm, 0mm, 0mm), radius=17.52mm)
  Circle2 = circle(normal=Z, centre=(0mm, 0mm, 0mm), radius=15.9mm)
  Circle1.subtract(Circle2)
  Rectangle1 = rectangle(corner=(-1.5mm, -30mm, 0mm), x_size=3mm, y_size=14mm)
  Rectangle1_1 = Rectangle1.duplicate_around_axis(axis=Z, angle=30deg, total=2)
  Rectangle1_2 = Rectangle1.duplicate_around_axis(axis=Z, angle=90deg, total=2)
  Rectangle1_3 = Rectangle1.duplicate_around_axis(axis=Z, angle=-90deg, total=2)
  Rectangle1_4 = Rectangle1.duplicate_around_axis(axis=Z, angle=-30deg, total=2)
  Rectangle1.delete()
  Circle1.unite(Rectangle1_1..Rectangle1_4)
  Circle1.rotate(axis=Z, angle=30deg)
  ground = regular_polygon(axis=Z, centre=(0mm, 0mm, 0mm), first_corner=(30/cos(30*pi/180) mm, 0mm, 0mm), sides=6)
  substrate [FR4_epoxy] = polyhedron(axis=Z, centre=(0mm, 0mm, 0mm), first_corner=(34.641016mm, 0mm, 0mm), sides=6, height=-1.6mm)
  ground.move(0mm, 0mm, -1.6mm)
  Rectangle2 = rectangle(corner=(-1.5mm, -30mm, 0mm), z_size=-1.6mm, x_size=3mm)
  Rectangle2_1 = Rectangle2.duplicate_around_axis(axis=Z, angle=60deg, total=2)
  Rectangle2_1_1 = Rectangle2_1.duplicate_around_axis(axis=Z, angle=60deg, total=2)
  Rectangle2_2 = Rectangle2.duplicate_around_axis(axis=Z, angle=-60deg, total=2)
  Box1 [air] = box(corner=(-50mm, -50mm, -50mm), size=(100mm, 100mm, 100mm))
boundaries and excitations:
  PerfE1: Perfect E Objects=[Circle1, ground]
  Rad1: Radiation Objects=Box1
  1: Lumped Port Objects=Rectangle2 LumpedPortType=Modal Modes{Mode1{IntLine{(0, -30, -1.6) -> (0, -30, 0)} CharImp=Zpi}} Impedance=50ohm
  2: Lumped Port Objects=Rectangle2_1 LumpedPortType=Modal Modes{Mode1{IntLine{(25.980762, -15, -1.6) -> (25.980762, -15, 0)} CharImp=Zpi}} Impedance=50ohm
  3: Lumped Port Objects=Rectangle2_1_1 LumpedPortType=Modal Modes{Mode1{IntLine{(25.980762, 15, -1.6) -> (25.980762, 15, 0)} CharImp=Zpi}} Impedance=50ohm
  4: Lumped Port Objects=Rectangle2_2 LumpedPortType=Modal Modes{Mode1{IntLine{(-25.980762, -15, -1.6) -> (-25.980762, -15, 0)} CharImp=Zpi}} Impedance=50ohm
setups:
  Setup1: HfssDriven Frequency=2.4GHz MaxDeltaS=0.02 MaximumPasses=6 MinimumPasses=1 MinimumConvergedPasses=1 PercentRefinement=30 BasisOrder=1 PortAccuracy=2 DrivenSolverType="Direct Solver"
    sweep Sweep: 1GHz to 5GHz, 100 points; Type=Interpolating InterpTolerance=0.5 InterpMaxSolns=250 PassivityErrorTolerance=0.0001
source amplitudes:
  1:1, 4:1: 0W 0deg
  2:1, 3:1: 1W 0deg
field plots:
  Mag_E1: E Field over Circle1.face(at (2.30269, -3.98838, 0)) ground.face(at (0, 0, -1.6)) on Setup1 : LastAdaptive at Freq=2.4GHz Phase=0deg
reports:
  S Parameter Plot 1: dB(S(1,1)), dB(S(1,2)), dB(S(1,3)), dB(S(1,4)) vs Freq on Setup1 : Sweep
